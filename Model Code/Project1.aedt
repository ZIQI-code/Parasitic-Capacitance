# Ansys Electronics Desktop project, version 2017.1
materials:
  vacuum: permittivity=1
  pec: conductivity=1e+030

design HFSSDesign1 (HFSS, DrivenModal, model units mm)
variables:
  radius = (47.2/2) mm
  pitch = 6.9mm
  turns = 10
  L = 8mm
  R_fiber = (3.25*2) mm
geometry:
  port [vacuum] = polyline((radius+L, 0mm+R_fiber/2, 0mm) (radius+L, turns*pitch -R_fiber/2, 0mm), section rectangle width=R_fiber)
  Sphere1 [vacuum] = sphere(centre=(50mm, 50mm, 0mm), radius=237.69729mm)
  EquationCurve2 [pec] = equation_curve(x=radius*cos(2*pi*_t), y=pitch*_t, z=radius*sin(2*pi*_t), _t=0 to turns, segments=36*turns+1, section Type=Circle Orient=Auto Width=R_fiber TopWidth=R_fiber Height=0 NumSegments=0 BendType=Corner)
  Polyline5 = polyline((radius-R_fiber/2, 0mm, 0mm) (radius+L+R_fiber/2, 0mm, 0mm), section rectangle width=R_fiber height=R_fiber)
  Polyline6 = polyline((radius-R_fiber/2, turns*pitch, 0mm) (radius+L +R_fiber/2, turns*pitch, 0mm), section rectangle width=R_fiber height=R_fiber)
  EquationCurve2.unite(Polyline5, Polyline6)
boundaries and excitations:
  PerfE1: Perfect E Objects=port
  Rad1: Radiation Objects=Sphere1
  PerfE2: Perfect E Objects=EquationCurve2
  1: Lumped Port Objects=port Modes{Mode1{IntLine{middle of port.edge(at (31.6, 3.25, 0)) -> middle of port.edge(at (31.6, 65.75, 0))} CharImp=Zpi RenormImp=50ohm}} Impedance=50ohm
setups:
  Setup1: HfssDriven Frequency=10MHz MaxDeltaS=0.02 MaximumPasses=6 MinimumPasses=1 MinimumConvergedPasses=1 PercentRefinement=30 BasisOrder=1 PortAccuracy=2 RayDensityPerWavelength=4 MaxNumberOfBounces=5
    sweep Sweep: 10kHz to 150MHz, 201 points; Type=Fast SaveFields
source amplitudes:
  1:1: 1W 0deg
optimetrics:
  ParametricSetup1: Parametric Sim._Setups=[Setup1]
    sweep turns: LIN 2 10 1
reports:
  Z Parameter Plot 1: re(Z(1,1)) vs Freq on Setup1 : Sweep [turns=all]; markers m1 at 126.75155MHz, m2 at 113.25245MHz, m3 at 103.5031MHz, m4 at 96.75355MHz, m5 at 90.75395MHz, m6 at 85.5043MHz, m7 at 81.0046MHz, m8 at 147.75015MHz, m9 at 113.25245MHz
  Z Parameter Plot 2: im(Z(1,1)) vs Freq on Setup1 : Sweep [turns=all]; markers MX1 at x=100000
